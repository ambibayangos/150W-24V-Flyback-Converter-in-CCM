# Ansys Electronics Desktop project, version 2022.1
materials:
  vacuum: permittivity=1
  ferrite: permittivity=12 permeability=1000 conductivity=0.01
  ferriteN87: permittivity=12 permeability=1650 conductivity=0.01
  copper: permeability=0.999991 conductivity=58000000
  air: permittivity=1.0006 permeability=1.0000004

design ETD44_2mmGap (Maxwell 3D, Magnetostatic, model units mm)
geometry:
  Core_A [ferriteN87] = box(corner=(-7.6mm, -21.9mm, 0mm), size=(15.2mm, 43.8mm, 22.5mm))
  Cylinder1 = cylinder(axis=Z, base_centre=(0mm, 0mm, 0mm), radius=16.25mm, height=16.1mm)
  Core_A.subtract(Cylinder1)
  Cylinder2 = cylinder(axis=Z, base_centre=(0mm, 0mm, 22.5mm), radius=7.6mm, height=-21.5mm)
  Core_A.unite(Cylinder2)
  Core_B [ferriteN87] = Core_A.duplicate_around_axis(axis=Y, angle=180deg, total=2)
  Coil [copper] = rectangle(corner=(0mm, -12mm, -8mm), y_size=2mm, z_size=16mm)
  Rectangle2 = rectangle(corner=(10mm, -11mm, 0mm), x_size=-20mm, y_size=22mm, uncovered)
  Coil.sweep_along_path(Rectangle2)
  Coil_Terminal [copper] = Coil.section(plane=YZ)
  Coil_Terminal.separate_bodies()
  Region [air] = region(percentage_offset=100 on all sides)
boundaries and excitations:
  Coil_Current: Current Objects=Coil_Terminal Current=2A IsSolid=false Point_out_of_terminal=true
parameters:
  Matrix1: Matrix Coil_Current: NumberOfTurns=1
mesh:
  initial mesh: GlobalCurvilinear{Apply}
setups:
  Setup1: Magnetostatic MaximumPasses=10 MinimumPasses=2 MinimumConvergedPasses=1 PercentRefinement=30 PercentError=1 ConstantDelta=0s NonLinearResidual=0.001
field plots:
  B_Vector1: B in Core_A, Core_B on Setup1 : LastAdaptive

design ETD44_1mmGap (Maxwell 3D, Magnetostatic, model units mm)
geometry:
  Box1 = box(corner=(-7.6mm, -21.9mm, 0mm), size=(15.2mm, 43.8mm, 22.5mm))
  Cylinder1 = cylinder(axis=Z, base_centre=(0mm, 0mm, 0mm), radius=16.25mm, height=16.1mm)
  Box1.subtract(Cylinder1)
  Core_A [ferriteN87] = cylinder(axis=Z, base_centre=(0mm, 0mm, 22.5mm), radius=7.6mm, height=-22mm)
  Core_A.unite(Box1)
  Core_B [ferriteN87] = Core_A.duplicate_around_axis(axis=Y, angle=180deg, total=2)
  Coil [copper] = rectangle(corner=(0mm, -12mm, -8mm), y_size=2mm, z_size=16mm)
  Rectangle2 = rectangle(corner=(10mm, -11mm, 0mm), x_size=-20mm, y_size=22mm, uncovered)
  Coil.sweep_along_path(Rectangle2)
  Coil_Terminal [copper] = Coil.section(plane=YZ)
  Coil_Terminal.separate_bodies()
  Region [air] = region(percentage_offset=100 on all sides)
boundaries and excitations:
  Coil_Current: Current Objects=Coil_Terminal Current=1A IsSolid=false Point_out_of_terminal=false
parameters:
  Matrix1: Matrix Coil_Current: NumberOfTurns=1
mesh:
  initial mesh: GlobalCurvilinear{Apply}
setups:
  Setup1: Magnetostatic MaximumPasses=10 MinimumPasses=2 MinimumConvergedPasses=1 PercentRefinement=30 PercentError=1 ConstantDelta=0s NonLinearResidual=0.001
